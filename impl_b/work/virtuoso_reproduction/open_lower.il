ddUpdateLibList()
envSetVal("layout" "stopLevel" 'int 32)
drLoadDrf("/mnt/c/EDA_Codex/Lab06b/reference/C01/outputs/m2_s7/virtuoso/report_colors.drf" nil)
tf=techGetTechFile(ddGetObj("lab06b_current_20261031"))
foreach(pair list(list("L3" "rptBlue" "blank") list("L41" "rptGreen" "solid") list("L39" "rptOrange" "solid") list("L4" "rptYellow" "solid") list("L5" "rptPink" "solid") list("L99" "rptBrown" "blank") list("L100" "rptLabel" "solid") list("L1002" "rptLabel" "blank"))
  lp=techGetLP(tf list(car(pair) "drawing"))
  when(lp drSetPacket("display" techGetLPPacketName(lp) caddr(pair) "solid" cadr(pair) cadr(pair) if(equal(caddr(pair) "blank") then "outline" else "solid")))
)
cv=dbOpenCellViewByType("lab06b_current_20261031" "lab06b_b7_ec_pad_chip" "layout" "" "r")
unless(cv error("Current OA cell view was not opened; stop reproduction"))
proof=outfile("/mnt/c/EDA_Codex/Lab06b/work/virtuoso_reproduction/out/oa_lower_readback.txt")
fprintf(proof "Library=lab06b_current_20261031\nCell=%s\nView=%s\nBBox=%L\nTopInstances=%d\n" cv~>cellName cv~>viewName cv~>bBox length(cv~>instances))
fprintf(proof "Cells=%L\n" ddGetObj("lab06b_current_20261031")~>cells~>name)
close(proof)
w=deOpenCellView("lab06b_current_20261031" "lab06b_b7_ec_pad_chip" "layout" "maskLayout" nil "r")
hiSetCurrentWindow(w)
geDisplayAllLayers()
hiZoomToFit(w)
printf("LAB06B_CURRENT_LOWER_OPENED\n")
