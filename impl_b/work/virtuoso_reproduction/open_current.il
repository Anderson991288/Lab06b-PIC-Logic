; Current Lab06b GDS only. New C-backed OA library; no historical library edited.
load("/home/EDA/mentor/calibre2026/aok_cal_2026.1_17.11/lib/calibre.skl")
envSetVal("layout" "stopLevel" 'int 32)
drLoadDrf("/mnt/c/EDA_Codex/Lab06b/reference/C01/outputs/m2_s7/virtuoso/report_colors.drf" nil)
tf=techGetTechFile(ddGetObj("LAB06B_REPRO_20261031"))
foreach(pair list(list("L3" "rptBlue" "blank") list("L41" "rptGreen" "solid") list("L39" "rptOrange" "solid") list("L4" "rptYellow" "solid") list("L5" "rptPink" "solid") list("L99" "rptBrown" "blank") list("L100" "rptLabel" "solid") list("L1002" "rptLabel" "blank"))
  lp=techGetLP(tf list(car(pair) "drawing"))
  when(lp drSetPacket("display" techGetLPPacketName(lp) caddr(pair) "solid" cadr(pair) cadr(pair) if(equal(caddr(pair) "blank") then "outline" else "solid")))
)
cv=dbOpenCellViewByType("LAB06B_REPRO_20261031" "LAB06B_B7_EC_PAD_CHIP" "layout" "" "r")
proof=outfile("/mnt/c/EDA_Codex/Lab06b/work/virtuoso_reproduction/out/oa_readback.txt")
fprintf(proof "Library=LAB06B_REPRO_20261031\nCell=LAB06B_B7_EC_PAD_CHIP\nView=layout\n")
fprintf(proof "CellView=%L\nBBox=%L\nTopInstances=%d\n" cv cv~>bBox length(cv~>instances))
fprintf(proof "Cells=%L\n" ddGetObj("LAB06B_REPRO_20261031")~>cells~>name)
close(proof)
deOpenCellView("LAB06B_REPRO_20261031" "LAB06B_B7_EC_PAD_CHIP" "layout" "maskLayout" nil "r")
hiZoomFit(hiGetCurrentWindow())
printf("LAB06B_REPRO_OPEN_COMPLETE\n")
